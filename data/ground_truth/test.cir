* Schematic AI Reasoner - SPICE Structural Netlist

R1 R1_1 R1_2 resistor

.end
